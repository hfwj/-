* Wizard nested model check
.include "../INA240A1_TI_8PIN_WIZARD.lib"
* TI INA240A1 pin-adapter comparison
V_SUP VA 0 3.3
X_W2 CM 0 0 NC2 W2 VA 0 IP INA240A1_TI_8PIN
X_W4 CM 0 0 NC4 W4 VA VA IP INA240A1_TI_8PIN
R_W2 W2 0 100k
R_W4 W4 0 100k
.options reltol=1e-4 abstol=1e-10 vntol=1e-6
V_CM CM 0 25
V_DIFF IP CM PWL(0 0 10u 0 10.01u 0.025 100u 0.025)
.tran 50n 100u 0 50n
.end
