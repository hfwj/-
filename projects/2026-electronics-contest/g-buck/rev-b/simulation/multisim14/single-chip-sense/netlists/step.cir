* Functional single-chip check
.include "../INA240A1_FUNC.lib"
.include "../INA181A1_FUNC.lib"
V_SUP VA 0 3.3
V_COMMON CM 0 25
X_U2 CM 0 0 NC_U2 O_IN VA 0 IP INA240A1_FUNC
X_U4 CM 0 0 NC_U4 O_IL VA VA IP INA240A1_FUNC
X_U3 O_OUT 0 IP CM 0 VA INA181A1_FUNC
R_IN_LOAD O_IN 0 1Meg
R_IL_LOAD O_IL 0 1Meg
R_OUT_LOAD O_OUT 0 1Meg
.options reltol=1e-5 abstol=1e-12 vntol=1e-8
V_DIFF IP CM PWL(0 0 5u 0 5.01u 0.025 20u 0.025)
.tran 10n 20u 0 10n
.end
