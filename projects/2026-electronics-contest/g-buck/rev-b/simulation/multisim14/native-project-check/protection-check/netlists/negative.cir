* RevB independent sensing/protection functional bench; noBuck plant or thermal fuse
V_DIG vd 0 3.3
V_5 v5 0 5
V_EXT vinext 0 25
V_CM vin 0 24.5
V_OUT vout 0 10
RS_IN shuntin vin .05
I_IN_LOOP vin shuntin .5
RS_OUT vcap vout .05
I_OUT_LOOP vout vcap .5
RS_L lraw vcap .025
I_IL_LOOP vcap lraw PWL(0 1 5m 1 5.001m -2.2 6m -2.2 6.001m 1 10m 1)
V_ARM arm 0 PWL(0 0 3m 0 3.00001m 3.3 3.1m 3.3 3.10001m 0 5.5m 0 5.50001m 3.3 7m 3.3 7.00001m 0 8m 0 8.00001m 3.3 8.1m 3.3 8.10001m 0)
V_MCU en 0 3.3
Xchain vinext shuntin vin lraw vcap vout vd v5 arm en 0 drv fault safe ilbi iin iout avin aiin avout aiout ail vp vn vo porc porok REVB_SENSE_PROTECT
I_VA_TEST xchain.va 0 0
.SUBCKT REVB_SENSE_PROTECT VIN_EXT V_SHUNT_IN VIN L_RAW V_CAP VOUT VDIG V5 ARM MCU_EN COM DRV_EN FAULT_N SAFE_OK IL_BI IIN_RAW IOUT_RAW ADC_VIN ADC_IIN ADC_VOUT ADC_IOUT ADC_IL VREF_POS VREF_NEG VREF_OV POR_RC POR_OK
* Original RevB passives and connectivity; explicitly FUNCTIONAL active-device model.
* No manufacturer INA/LM393/HC model, no certified latency/common-mode/offset/loss validation.
* MODEL-only RC poles: INA1us, comparator0.3us, digital edge100ns; not added BOM parts.
R_VDDA VDIG VA 10
C_A1 VA COM 1u
C_A2 VA COM 100n
C_A3 VA COM 10u
C_U2 VA COM 100n
C_U3 VA COM 100n
C_U4 VA COM 100n
* INA240 input: pins8+,1-,REF1/REF2=0; gain20.
E_U2_RAW U2_RAW COM VALUE={LIMIT(20*V(V_SHUNT_IN,VIN),0,MAX(V(VA,COM),0))}
R_M_U2 U2_RAW U2_F 1k
C_M_U2 U2_F COM 1n
E_U2_BUF U2_CMD COM VALUE={V(U2_F,COM)}
R_M_U2_OUT U2_CMD IIN_RAW 1
* INA181 output: pins3+,4-,REF=0; gain20.
E_U3_RAW U3_RAW COM VALUE={LIMIT(20*V(V_CAP,VOUT),0,MAX(V(VA,COM),0))}
R_M_U3 U3_RAW U3_F 1k
C_M_U3 U3_F COM 1n
E_U3_BUF U3_CMD COM VALUE={V(U3_F,COM)}
R_M_U3_OUT U3_CMD IOUT_RAW 1
* INA240 inductor: pins8+,1-,REF1=VA,REF2=0; zero=VA/2.
E_U4_RAW U4_RAW COM VALUE={LIMIT(20*V(L_RAW,V_CAP)+0.5*V(VA,COM),0,MAX(V(VA,COM),0))}
R_M_U4 U4_RAW U4_F 1k
C_M_U4 U4_F COM 1n
E_U4_BUF U4_CMD COM VALUE={V(U4_F,COM)}
R_M_U4_OUT U4_CMD IL_BI 1
* Actual voltage dividers and ADC branches.
R1 VIN_EXT VIN_DIV 100k
R2 VIN_DIV COM 10k
R4 VOUT VOUT_DIV 10k
R5 VOUT_DIV COM 1k
R3 VIN_DIV ADC_VIN 1k
C7 ADC_VIN COM 4.7n
R7 IIN_RAW ADC_IIN 1k
C9 ADC_IIN COM 4.7n
R6 VOUT_DIV ADC_VOUT 1k
C8 ADC_VOUT COM 4.7n
R8 IOUT_RAW ADC_IOUT 1k
C10 ADC_IOUT COM 4.7n
R_IL_ADC IL_BI ADC_IL 1k
C_IL_ADC ADC_IL COM 4.7n
* BAT54S series midpoint orientation, qualitative diode model only.
D_ADC1_LO COM ADC_VIN D_FUNC
D_ADC1_HI ADC_VIN VDIG D_FUNC
D_ADC2_LO COM ADC_IIN D_FUNC
D_ADC2_HI ADC_IIN VDIG D_FUNC
D_ADC3_LO COM ADC_VOUT D_FUNC
D_ADC3_HI ADC_VOUT VDIG D_FUNC
D_ADC4_LO COM ADC_IOUT D_FUNC
D_ADC4_HI ADC_IOUT VDIG D_FUNC
D_ADC5_LO COM ADC_IL D_FUNC
D_ADC5_HI ADC_IL VDIG D_FUNC
* References: these R/C values are original physical parts.
R9 VA VREF_POS 10k
R10A VREF_POS POS_MID 33k
R10B POS_MID COM 1k
C_REF_POS VREF_POS COM 100n
R15A VA NEG_MID 33k
R15B NEG_MID VREF_NEG 1k
R16 VREF_NEG COM 10k
C_REF_NEG VREF_NEG COM 100n
R11 VA VREF_OV 23k
R12 VREF_OV COM 10k
C_REF_OV VREF_OV COM 100n
* LM393 channels: original input polarity; collector pulls FAULT_N low.
E_U5A_DIFF U5A_D COM VALUE={V(IL_BI,VREF_POS)}
R_M_U5A U5A_D U5A_F 1k
C_M_U5A U5A_F COM 300p
S_U5A FAULT_N COM U5A_F COM OC_FUNC
E_U9A_DIFF U9A_D COM VALUE={V(VREF_NEG,IL_BI)}
R_M_U9A U9A_D U9A_F 1k
C_M_U9A U9A_F COM 300p
S_U9A FAULT_N COM U9A_F COM OC_FUNC
E_U5B_DIFF U5B_D COM VALUE={V(VOUT_DIV,VREF_OV)}
R_M_U5B U5B_D U5B_F 1k
C_M_U5B U5B_F COM 300p
S_U5B FAULT_N COM U5B_F COM OC_FUNC
R13 VDIG FAULT_N 10k
C_M_FAULT FAULT_N COM 30p
* Original power/reset passives; HC14 assumed normalized thresholds0.3/0.6.
R14 VDIG POR_RC 10k
C11 POR_RC COM 100n IC=0
E_POR_RATIO1 POR_RATIO1 COM VALUE={V(POR_RC,COM)/MAX(V(VDIG,COM),0.1)}
V_M_ONE M_ONE COM 1
R_M_SCH1 M_ONE SCH1 1k
S_M_SCH1 SCH1 COM POR_RATIO1 COM SCH_FUNC
C_M_SCH1 SCH1 COM 10p
E_U8A_CMD POR_INV_CMD COM VALUE={V(VDIG,COM)*V(SCH1,COM)}
R_M_U8A POR_INV_CMD POR_INV 50
E_POR_RATIO2 POR_RATIO2 COM VALUE={V(POR_INV,COM)/MAX(V(VDIG,COM),0.1)}
R_M_SCH2 M_ONE SCH2 1k
S_M_SCH2 SCH2 COM POR_RATIO2 COM SCH_FUNC
C_M_SCH2 SCH2 COM 10p
E_U8B_CMD POR_OK_CMD COM VALUE={V(VDIG,COM)*V(SCH2,COM)}
R_M_U8B POR_OK_CMD POR_OK 50
D_POR FAULT_N POR_OK D_FUNC
* HC74 functional edge/memory equivalent; D=/PRE tied high, async /CLR=FAULT_N.
R_ARM_PD ARM COM 10k
R_EN_PD MCU_EN COM 10k
E_CLK_BIT CLK_BIT COM VALUE={IF(V(ARM,COM)>0.5*MAX(V(VDIG,COM),0.1),1,0)}
R_M_CLK CLK_BIT CLK_DELAY 1k
C_M_CLK CLK_DELAY COM 100p
E_EDGE ARM_EDGE COM VALUE={IF(V(CLK_BIT,COM)>0.5,IF(V(CLK_DELAY,COM)<0.5,1,0),0)}
E_SET SET_CMD COM VALUE={IF(V(FAULT_N,COM)>0.7*MAX(V(VDIG,COM),0.1),V(ARM_EDGE,COM),0)}
E_CLEAR CLEAR_CMD COM VALUE={IF(V(FAULT_N,COM)<0.3*MAX(V(VDIG,COM),0.1),1,0)}
S_M_SET VDIG Q_MEM SET_CMD COM BOOL_FUNC
S_M_CLEAR Q_MEM COM CLEAR_CMD COM BOOL_FUNC
C_M_Q Q_MEM COM 10p IC=0
R_M_Q Q_MEM COM 1T
E_U6_Q Q_CMD COM VALUE={IF(V(Q_MEM,COM)>0.5*MAX(V(VDIG,COM),0.1),V(VDIG,COM),0)}
R_M_U6_Q Q_CMD SAFE_OK 50
C_M_U6_Q SAFE_OK COM 10p
* HC08 used gate: SAFE_OK AND MCU_EN; ordinary MCU disable does not clear latch.
E_U7_CMD DRV_CMD COM VALUE={IF(V(SAFE_OK,COM)>0.5*MAX(V(VDIG,COM),0.1),IF(V(MCU_EN,COM)>0.5*MAX(V(VDIG,COM),0.1),V(VDIG,COM),0),0)}
R_M_U7 DRV_CMD DRV_EN 50
C_M_U7 DRV_EN COM 10p
* Decoupling capacitors from original rails; active quiescent currents omitted.
C_U5 V5 COM 100n
C_U9 V5 COM 100n
C_U6 VDIG COM 100n
C_U7 VDIG COM 100n
C_U8 VDIG COM 100n
* Models are study assumptions; 1uV comparator hysteresis is numerical stabilization.
.MODEL OC_FUNC SW(Ron=10 Roff=1e12 Vt=0 Vh=1u)
.MODEL BOOL_FUNC SW(Ron=100 Roff=1e12 Vt=0.5 Vh=0)
.MODEL SCH_FUNC SW(Ron=0.001 Roff=1e12 Vt=0.45 Vh=0.15)
.MODEL D_FUNC D(Is=1e-8 N=1.05 Rs=2 Cjo=10p Bv=30)
.ENDS REVB_SENSE_PROTECT

.options reltol=0.001 abstol=1e-10 vntol=1e-6 method=gear
.save v(drv) v(fault) v(safe) v(ilbi) v(iin) v(iout) v(avin) v(aiin) v(avout) v(aiout) v(ail) v(vp) v(vn) v(vo) v(porc) v(porok) v(arm) v(en) v(xchain.va) v(vout)
.tran 100n 10m 0 200n uic

.end
